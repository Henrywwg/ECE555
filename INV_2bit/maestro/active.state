ADE simulation setup
Test ECE555_INV_2bit_1: ECE555/INV_2bit/schematic, simulator hspiceD
Run mode: Single Run, Sweeps and Corners
