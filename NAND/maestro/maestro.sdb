ADE simulation setup
Run mode: Single Run, Sweeps and Corners
Tests:
  ECE555_NAND_1: ECE555/NAND/schematic, simulator hspiceD
