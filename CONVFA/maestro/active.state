ADE simulation setup
Test ECE555_CONVFA_1: ECE555/CONVFA/schematic, simulator hspiceD
Run mode: Single Run, Sweeps and Corners
