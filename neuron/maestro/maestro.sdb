ADE simulation setup
Run mode: Single Run, Sweeps and Corners
Tests:
  ECE555_neuron_1: ECE555/neuron/schematic, simulator hspiceD
