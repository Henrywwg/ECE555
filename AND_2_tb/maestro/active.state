ADE simulation setup
Test ECE555_AND_2_tb_1: ECE555/AND_2_tb/schematic, simulator hspiceD
Run mode: Single Run, Sweeps and Corners
