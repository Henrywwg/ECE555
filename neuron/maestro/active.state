ADE simulation setup
Test ECE555_neuron_1: ECE555/neuron/schematic, simulator hspiceD
Run mode: Single Run, Sweeps and Corners
