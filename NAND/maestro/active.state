ADE simulation setup
Test ECE555_NAND_1: ECE555/NAND/schematic, simulator hspiceD
Run mode: Single Run, Sweeps and Corners
