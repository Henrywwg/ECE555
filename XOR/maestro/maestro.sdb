ADE simulation setup
Run mode: Single Run, Sweeps and Corners
Tests:
  ECE555_XOR_1: ECE555/XOR/schematic, simulator hspiceD
