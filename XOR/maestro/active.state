ADE simulation setup
Test ECE555_XOR_1: ECE555/XOR/schematic, simulator hspiceD
Run mode: Single Run, Sweeps and Corners
