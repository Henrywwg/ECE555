ADE simulation setup
Test ECE555_AND_2_1: ECE555/AND_2/schematic, simulator hspiceD
Run mode: Single Run, Sweeps and Corners
