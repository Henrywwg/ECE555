ADE simulation setup
Run mode: Single Run, Sweeps and Corners
Tests:
  ECE555_CONVFA_1: ECE555/CONVFA/schematic, simulator hspiceD
