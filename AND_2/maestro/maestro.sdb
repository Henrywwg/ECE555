ADE simulation setup
Run mode: Single Run, Sweeps and Corners
Tests:
  ECE555_AND_2_1: ECE555/AND_2/schematic, simulator hspiceD
